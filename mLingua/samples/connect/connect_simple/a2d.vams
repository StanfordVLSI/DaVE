// Electrical to Logic Connect Module
//
// Version 1a, 1 June 04
//
// Olaf Zinke
//
// Downloaded from The Designer's Guide Community (www.designers-guide.org).
// Post any questions on www.designers-guide.org/Forum.
// Taken from "The Designer's Guide to Verilog-AMS" by Kundert & Zinke.
// Chapter 4, Listing 16.

`include "disciplines.vams"

connectmodule a2d (out, in);
    parameter real v1 = 1.0; // supply
    parameter real v0 = 0.0; // supply
    parameter real vh = (v1-v0)*2/3+v0;	// minimum voltage of a logic 1 (V)
    parameter real vl = (v1-v0)*1/3+v0;	// maximum voltage of a logic 0 (V)
//    parameter real c = 1f;	// input capacitance (F)
    parameter real vtol=(v1-v0)/100 from (0:(vh-vl)/4]; // voltage tolerance
    parameter real tr=20p from (0:1m);              // risetime (for defaults)
    parameter real ttol=tr/4;                       // time tolerance of crossing

    input in;
    output out;
    electrical in;
    reg out;
    logic out;

    // when analog rises above the high threshold, digital becomes 1
    always @(above(V(in) - vh), ttol, vtol)
	out = 1'b1;

    // when analog falls below the low threshold, digital becomes 0
    always @(above(vl - V(in)), ttol, vtol)
	out = 1'b0;

//    analog
//	I(in) <+ c*ddt(V(in));
endmodule
