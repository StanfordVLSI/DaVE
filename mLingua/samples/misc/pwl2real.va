/****************************************************************

Copyright (c) 2018- Stanford University. All rights reserved.

The information and source code contained herein is the
property of Stanford University, and may not be disclosed or
reproduced in whole or in part without explicit written
authorization from Stanford University. Contact bclim@stanford.edu for details.

* Filename   : pwl2real.va
* Author     : Byongchan Lim (bclim@stanford.edu)
* Description: Counterpart of "pwl2real.v". Signal feedthrough
  in Verilog-AMS.

* Note       :

* Revision   :
  - 7/26/2016: First release

****************************************************************/

`include "disciplines.vams"
`timescale `DAVE_TIMEUNIT / `DAVE_TIMEUNIT

module pwl2real #(
  parameter real dv = 0.0  //
) (
  input in,
  output out
);

electrical in, out;

analog begin
  V(out) <+ V(in);
end

endmodule
