/****************************************************************

Copyright (c) 2018- Stanford University. All rights reserved.

The information and source code contained herein is the
property of Stanford University, and may not be disclosed or
reproduced in whole or in part without explicit written
authorization from Stanford University. Contact bclim@stanford.edu for details.

* Filename   : res.va
* Author     : Byongchan Lim (bclim@stanford.edu)
* Description: A resistor, valid for Verilog-AMS only.

* Note       :

* Revision   :
  - 7/26/2016: First release

****************************************************************/

`include "discipline.h"

module res(pn, nn);
inout pn, nn;
electrical pn, nn;
parameter real r=0 from [0:inf);

analog begin
  V(pn, nn) <+ r*I(pn, nn);
end

endmodule
